// Design: TIATest/V2
simulator lang=spectre
global 0
//parameters R=1K L=180n W1=10u W5=2u W6=2.6u W2=0.9*W1 W3=2*W1 W4=0.9*W3
include "./params.scs"
include "/ubc/ece/data/cmc2/kits/GPDK45/gpdk045_v_6_0/gpdk045/../models/spectre/gpdk045.scs" section=mc

// TIATest/V2/schematic
NM3 (net013 net7 0 0) g45n1svt w=(W6) l=L nf=ceil(((W6) - 5p) / (10u)) m=(1)
NM1 (net7 net5 0 0) g45n1svt w=(W4) l=L nf=ceil(((W4) - 5p) / (10u)) m=(1)
NM2 (net5 net5 0 0) g45n1svt w=(W1) l=L nf=ceil(((W1) - 5p) / (10u)) m=(1)
PM2 (net013 net020 net10 net10) g45p1svt w=(W5) l=L nf=ceil(((W5) - 5p) / (10u)) m=(1)
PM1 (net7 net5 net10 net10) g45p1svt w=(W3) l=L nf=ceil(((W3) - 5p) / (10u)) m=(1)
PM0 (net5 net5 net10 net10) g45p1svt w=(W2) l=L nf=ceil(((W2) - 5p) / (10u)) m=(1)
C1 (net013 0) capacitor c=1.00f
R0 (net5 net7) resistor r=R
V1 (net10 net020) vsource dc=500m type=dc
V0 (net10 0) vsource dc=1 type=dc
I2 (net5 0) isource dc=0 mag=100u phase=0 type=sine sinedc=0 ampl=100u sinephase=0 freq=10K
simulatorOptions options temp=27
//dcOp dc write="spectre.dc" maxiters=150 maxsteps=10000 annotate=status
//dcOpInfo info what=oppoint where=rawfile
ac ac start=1M stop=10G

//Save options
//save I2:sink
save I2:sink net013
//saveOptions options save=allpub
