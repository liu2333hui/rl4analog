// Design: MyFirstLib/OpAmpV1.4.2
simulator lang=spectre
global 0
//parameters K=1.35 W6=1.13u W11=1u VN2=900m S=2 VN=900m VP=300m W8=4u F=1k // W12=4.5u W2=600n W1=6u A=0.01 L=245n W10=W8 W7=W6
include "./params.scs"
include "/ubc/ece/data/cmc2/kits/GPDK45/gpdk045_v_6_0/gpdk045/../models/spectre/gpdk045.scs" section=mc

// MyFirstLib/OpAmpV1.4.2/schematic
NM27 (net12 net20 0 0) g45n1svt w=(W2) l=L nf=1 m=(1)
NM24 (Vn2 Vn2 net12 net12) g45n1svt w=(W11) l=L nf=1 m=(1)
NM35 (Vp net20 0 0) g45n1svt w=(W2) l=L nf=1 m=(1)
NM26 (net20 net20 0 0) g45n1svt w=(W2) l=L nf=1 m=(1)
NM23 (net21 Vn2 net14 net14) g45n1svt w=(W7*K) l=L nf=1 m=(1)
NM22 (net14 net4 0 0) g45n1svt w=(W6*K) l=L nf=1 m=(1)
NM20 (net10 net3 0 0) g45n1svt w=(W2) l=L nf=1 m=(1)
NM21 (net7 Vn2 net10 net10) g45n1svt w=(W11) l=L nf=1 m=(1)
NM1 (net4 net4 0 0) g45n1svt w=(W2) l=L nf=1 m=(1)
NM0 (net3 net3 0 0) g45n1svt w=(W2) l=L nf=1 m=(1)
PM27 (Vp Vp net16 net16) g45p1svt w=(W8*K) l=L nf=ceil(((W8*K) - 5p) / (10u)) m=(1)
PM28 (Vp Vp net16 net16) g45p1svt w=(W8/S) l=L nf=1 m=(1)
PM25 (Vn2 net8 net16 net16) g45p1svt w=(2.8u) l=L nf=1 m=(1)
PM29 (net9 net9 Vp Vp) g45p1svt w=(W10*K) l=L nf=ceil(((W10*K) - 5p) / (10u)) m=(1)
PM22 (net7 net7 net16 net16) g45p1svt w=(W8/S) l=L nf=1 m=(1)
PM18 (net20 net8 net16 net16) g45p1svt w=(2u) l=L nf=1 m=(1)
PM23 (net13 net7 net16 net16) g45p1svt w=(W8*K) l=L nf=ceil(((W8*K) - 5p) / (10u)) m=(1)
PM24 (net21 Vpp net13 net13) g45p1svt w=(W10*K) l=L nf=ceil(((W10*K) - 5p) / (10u)) m=(1)
PM11 (net8 net8 net16 net16) g45p1svt w=(150n) l=L nf=1 m=(1)
PM7 (net1 net8 net16 net16) g45p1svt w=(W12) l=L nf=1 m=(1)
PM1 (net4 net11 net1 net1) g45p1svt w=(W1) l=L nf=1 m=(1)
PM0 (net3 net2 net1 net1) g45p1svt w=(W1) l=L nf=1 m=(1)
I18 (net9 0) isource dc=40u type=dc
I9 (net8 0) isource dc=2u type=dc
C0 (net21 0) capacitor c=2p
V7 (net11 net6) vsource dc=0 mag=-A phase=0 type=sine ampl=-A sinephase=0 freq=F
Vin (net2 net6) vsource dc=0 mag=A phase=0 type=sine ampl=A sinephase=0 freq=F
R0 (Vpp 0) resistor r=1K
V5 (Vpp 0) vsource dc=VP type=sine
V1 (net16 0) vsource dc=1 type=sine
V6 (net6 0) vsource dc=300m type=sine
simulatorOptions options temp=27
ac ac start=10 stop=10M
save net11 net21
// V6:p V6:p
//saveOptions options save=allpub
